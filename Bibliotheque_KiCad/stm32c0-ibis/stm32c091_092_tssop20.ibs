| IBIS file stm32c091_092_tssop20.ibs
[IBIS ver] 4.2
[File name] stm32c091_092_tssop20.ibs
[File Rev] 0.1
[Date] 13-01-2025
[Source] Data Created at STMicroelectronics
[Notes]  File originated from ELDO simulations.
[Disclaimer]  This information is for modeling purpose only and is
   not guaranted. The information is subject to change without
   notice.
[Copyright] Copyright 2025 STMicroelectronics Inc.
|   Component stm32c091_092_tssop20
[Component] stm32c091_092_tssop20
[Manufacturer] STMicroelectronics
[Package]
| variable   typ   min   max
R_pkg  0  NA  NA
L_pkg  0  NA  NA
C_pkg  0  NA  NA
[Pin]   signal_name   model_name
| choose one IO only for pin 1
1  PB7  io8_ft_i2c
|1  PB8  io8_ft_i2c
2  PC14-OSCX_IN  io8_ft_i2c
3  PC15-OSCX_OUT  io8_ft
4  VDD  power
5  VSS  gnd
6  PF2-NRST  ioreset_ft_v33
7  PA0  io8_ft_v33
8  PA1  io8_ft
9  PA2  io8_ft_v33
10  PA3  io8_ft
11  PA4  io8_ft_v33
12  PA5  io8_ft
13  PA6  io8_ft_i2c
14  PA7  io8_ft_i2c
| choose one IO only for pin 15
15  PB0  io8_ft
|15  PB1  io8_ft
|15  PB2  io8_ft
|15  PA8  io8_ft
16  PA11  io8_ft_i2c
17  PA12  io8_ft_i2c
18  PA13  io8_ft
| choose one IO only for pin 19
19  PA14-BOOT0  io8_ft_v33
|19  PA15  io8_ft
| choose one IO only for pin 20
20  PB3  io8_ft_i2c
|20  PB4  io8_ft_i2c
|20  PB5  io8_ft_i2c_v33
|20  PB6  io8_ft_i2c_v33
[Package Model]   44d-tssop-4.4-20-241210
[Pin Mapping]   pulldown_ref   pullup_ref   | Comment
1  gndio  vddio
2  gndio  vddio
3  gndio  vddio
4  nc  vddio
5  gndio  nc
6  gndio  vddio
7  gndio  vddio
8  gndio  vddio
9  gndio  vddio
10  gndio  vddio
11  gndio  vddio
12  gndio  vddio
13  gndio  vddio
14  gndio  vddio
15  gndio  vddio
16  gndio  vddio
17  gndio  vddio
18  gndio  vddio
19  gndio  vddio
20  gndio  vddio
|[Diff Pin]  inv_pin  vdiff  tdelay_typ  tdelay_min  tdelay_max
|17  16  NA  NA  NA  NA
[Model Selector] io8_ft
io8_ft_ls_3v3 "GPIO - 5V tolerant - low speed - 3.3V range"
io8_ft_ms_3v3 "GPIO - 5V tolerant - med speed - 3.3V range"
io8_ft_fs_3v3 "GPIO - 5V tolerant - fast speed - 3.3V range"
io8_ft_hs_3v3 "GPIO - 5V tolerant - high speed - 3.3V range"
io8_ft_ls_1v8 "GPIO - 5V tolerant - low speed - 1.8V range"
io8_ft_ms_1v8 "GPIO - 5V tolerant - med speed - 1.8V range"
io8_ft_fs_1v8 "GPIO - 5V tolerant - fast speed - 1.8V range"
io8_ft_hs_1v8 "GPIO - 5V tolerant - high speed - 1.8V range"
io8_ft_ls_1v2 "GPIO - 5V tolerant - low speed - 1.2V range"
io8_ft_ms_1v2 "GPIO - 5V tolerant - med speed - 1.2V range"
io8_ft_fs_1v2 "GPIO - 5V tolerant - fast speed - 1.2V range"
io8_ft_hs_1v2 "GPIO - 5V tolerant - high speed - 1.2V range"
[Model Selector] io8_ft_i2c
io8_ft_ls_3v3 "GPIO - 5V tolerant - low speed - 3.3V range"
io8_ft_ms_3v3 "GPIO - 5V tolerant - med speed - 3.3V range"
io8_ft_fs_3v3 "GPIO - 5V tolerant - fast speed - 3.3V range"
io8_ft_hs_3v3 "GPIO - 5V tolerant - high speed - 3.3V range"
io8_ft_ls_1v8 "GPIO - 5V tolerant - low speed - 1.8V range"
io8_ft_ms_1v8 "GPIO - 5V tolerant - med speed - 1.8V range"
io8_ft_fs_1v8 "GPIO - 5V tolerant - fast speed - 1.8V range"
io8_ft_hs_1v8 "GPIO - 5V tolerant - high speed - 1.8V range"
io8_ft_ls_1v2 "GPIO - 5V tolerant - low speed - 1.2V range"
io8_ft_ms_1v2 "GPIO - 5V tolerant - med speed - 1.2V range"
io8_ft_fs_1v2 "GPIO - 5V tolerant - fast speed - 1.2V range"
io8_ft_hs_1v2 "GPIO - 5V tolerant - high speed - 1.2V range"
io8_ft_i2c_ls_3v3 "GPIO with I2C open-drain - 5V tolerant - low speed - 3.3V range"
io8_ft_i2c_ms_3v3 "GPIO with I2C open-drain - 5V tolerant - med speed - 3.3V range"
io8_ft_i2c_fs_3v3 "GPIO with I2C open-drain - 5V tolerant - fast speed - 3.3V range"
io8_ft_i2c_hs_3v3 "GPIO with I2C open-drain - 5V tolerant - high speed - 3.3V range"
io8_ft_i2c_ls_1v8 "GPIO with I2C open-drain - 5V tolerant - low speed - 1.8V range"
io8_ft_i2c_ms_1v8 "GPIO with I2C open-drain - 5V tolerant - med speed - 1.8V range"
io8_ft_i2c_fs_1v8 "GPIO with I2C open-drain - 5V tolerant - fast speed - 1.8V range"
io8_ft_i2c_hs_1v8 "GPIO with I2C open-drain - 5V tolerant - high speed - 1.8V range"
io8_ft_i2c_ls_1v2 "GPIO with I2C open-drain - 5V tolerant - low speed - 1.2V range"
io8_ft_i2c_ms_1v2 "GPIO with I2C open-drain - 5V tolerant - med speed - 1.2V range"
io8_ft_i2c_fs_1v2 "GPIO with I2C open-drain - 5V tolerant - fast speed - 1.2V range"
io8_ft_i2c_hs_1v2 "GPIO with I2C open-drain - 5V tolerant - high speed - 1.2V range"
io8_ft_i2c_fmp_3v3 "GPIO with I2C fm+ open-drain - 5V tolerant - 3.3V range"
[Model Selector] io8_ft_v33
io8_ft_v33_ls_3v3 "GPIO - 5V tolerant - low speed - 3.3V range"
io8_ft_v33_ms_3v3 "GPIO - 5V tolerant - med speed - 3.3V range"
io8_ft_v33_fs_3v3 "GPIO - 5V tolerant - fast speed - 3.3V range"
io8_ft_v33_hs_3v3 "GPIO - 5V tolerant - high speed - 3.3V range"
io8_ft_v33_ls_1v8 "GPIO - 5V tolerant - low speed - 1.8V range"
io8_ft_v33_ms_1v8 "GPIO - 5V tolerant - med speed - 1.8V range"
io8_ft_v33_fs_1v8 "GPIO - 5V tolerant - fast speed - 1.8V range"
io8_ft_v33_hs_1v8 "GPIO - 5V tolerant - high speed - 1.8V range"
io8_ft_v33_ls_1v2 "GPIO - 5V tolerant - low speed - 1.2V range"
io8_ft_v33_ms_1v2 "GPIO - 5V tolerant - med speed - 1.2V range"
io8_ft_v33_fs_1v2 "GPIO - 5V tolerant - fast speed - 1.2V range"
io8_ft_v33_hs_1v2 "GPIO - 5V tolerant - high speed - 1.2V range"
[Model Selector] ioreset_ft_v33
io8_ft_v33_ls_3v3 "GPIO - 5V tolerant - low speed - 3.3V range"
io8_ft_v33_ms_3v3 "GPIO - 5V tolerant - med speed - 3.3V range"
io8_ft_v33_fs_3v3 "GPIO - 5V tolerant - fast speed - 3.3V range"
io8_ft_v33_hs_3v3 "GPIO - 5V tolerant - high speed - 3.3V range"
io8_ft_v33_ls_1v8 "GPIO - 5V tolerant - low speed - 1.8V range"
io8_ft_v33_ms_1v8 "GPIO - 5V tolerant - med speed - 1.8V range"
io8_ft_v33_fs_1v8 "GPIO - 5V tolerant - fast speed - 1.8V range"
io8_ft_v33_hs_1v8 "GPIO - 5V tolerant - high speed - 1.8V range"
io8_ft_v33_ls_1v2 "GPIO - 5V tolerant - low speed - 1.2V range"
io8_ft_v33_ms_1v2 "GPIO - 5V tolerant - med speed - 1.2V range"
io8_ft_v33_fs_1v2 "GPIO - 5V tolerant - fast speed - 1.2V range"
io8_ft_v33_hs_1v2 "GPIO - 5V tolerant - high speed - 1.2V range"
ioreset_ft_v33_1v2   "Reset PAD. 5V tolerant. 1.2V range"
ioreset_ft_v33_1v8   "Reset PAD. 5V tolerant. 1.8V range"
ioreset_ft_v33_3v3   "Reset PAD. 5V tolerant. 3.3V range"
[Define Package Model]  44d-tssop-4.4-20-241210
[Manufacturer]  Unknown
[OEM]  Unknown
[Description]  None
[Number Of Pins]  20
[Pin Numbers]
| Pin Num   Terminal Name
7 | PA0
8 | PA1
9 | PA2
10 | PA3
11 | PA4
12 | PA5
13 | PA6
14 | PA7
16 | PA11
17 | PA12
18 | PA13
19 | PA14-BOOT0-PA15
15 | PB0-PB1-PB2-PA8
20 | PB3-PB4-PB5-PB6
1 | PB7-PB8
2 | PC14-OSCX_IN
3 | PC15-OSCX_OUT
6 | PF2-NRST
4 | VDD
5 | VSS
[Model Data]
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[End Model Data]
[End Package Model]
|End [Component]
| Models and submodels in the file (40): io8_ft_fs_1v2 (I/O), io8_ft_fs_1v8 (I/O), io8_ft_fs_3v3 (I/O), io8_ft_hs_1v2 (I/O), io8_ft_hs_1v8 (I/O), io8_ft_hs_3v3 (I/O), io8_ft_i2c_fmp_3v3 (I/O_open_drain), io8_ft_i2c_fs_1v2 (I/O_open_drain), io8_ft_i2c_fs_1v8 (I/O_open_drain), io8_ft_i2c_fs_3v3 (I/O_open_drain), io8_ft_i2c_hs_1v2 (I/O_open_drain), io8_ft_i2c_hs_1v8 (I/O_open_drain), io8_ft_i2c_hs_3v3 (I/O_open_drain), io8_ft_i2c_ls_1v2 (I/O_open_drain), io8_ft_i2c_ls_1v8 (I/O_open_drain), io8_ft_i2c_ls_3v3 (I/O_open_drain), io8_ft_i2c_ms_1v2 (I/O_open_drain), io8_ft_i2c_ms_1v8 (I/O_open_drain), io8_ft_i2c_ms_3v3 (I/O_open_drain), io8_ft_ls_1v2 (I/O), io8_ft_ls_1v8 (I/O), io8_ft_ls_3v3 (I/O), io8_ft_ms_1v2 (I/O), io8_ft_ms_1v8 (I/O), io8_ft_ms_3v3 (I/O), io8_ft_v33_fs_1v2 (I/O), io8_ft_v33_fs_1v8 (I/O), io8_ft_v33_fs_3v3 (I/O), io8_ft_v33_hs_1v2 (I/O), io8_ft_v33_hs_1v8 (I/O), io8_ft_v33_hs_3v3 (I/O), io8_ft_v33_ls_1v2 (I/O), io8_ft_v33_ls_1v8 (I/O), io8_ft_v33_ls_3v3 (I/O), io8_ft_v33_ms_1v2 (I/O), io8_ft_v33_ms_1v8 (I/O), io8_ft_v33_ms_3v3 (I/O), ioreset_ft_v33_1v2 (Input), ioreset_ft_v33_1v8 (Input), ioreset_ft_v33_3v3 (Input)
