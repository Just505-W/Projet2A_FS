| IBIS file stm32c071_ufbga64_n.ibs
[IBIS ver] 4.2
[File name] stm32c071_ufbga64_n.ibs
[File Rev] 0.1
[Date] 27-05-2024
[Source] Data Created at STMicroelectronics
[Notes]  File originated from ELDO simulations.
[Disclaimer]  This information is for modeling purpose only and is
   not guaranteed. The information is subject to change without
   notice.
[Copyright] Copyright 2024 STMicroelectronics Inc.
|   Component stm32c071_ufbga64_n
[Component] stm32c071_ufbga64_n
[Manufacturer] STMicroelectronics
[Package]
| variable   typ   min   max
R_pkg  0  NA  NA
L_pkg  0  NA  NA
C_pkg  0  NA  NA
[Pin]   signal_name   model_name
A1  PC11  io8_ft
A2  PC10  io8_ft
A3  PB7  io8_ft_i2c
A4  PB6  io8_ft_i2c_v33
A5  PD6  io8_ft
A6  PD2  io8_ft
A7  PD0  io8_ft
A8  PC8  io8_ft
B1  PC15-OSCX_OUT  io8_ft
B2  PC12  io8_ft
B3  PB8  io8_ft_i2c
B4  PB3  io8_ft_i2c
B5  PD5  io8_ft
B6  PD1  io8_ft
B7  PC9  io8_ft
B8  PA12  io8usb_ft_i2c_phy
C1  PC14-OSCX_IN  io8_ft_i2c
C2  PC13  io8_ft_v33
C3  PB9  io8_ft_i2c
C4  PB4  io8_ft_i2c
C5  PD4  io8_ft
C6  PA15  io8_ft
C7  PA14-BOOT0  io8_ft_v33
C8  PA11  io8usb_ft_i2c_phy
D1  VDD  power
D2  VREFP  nc
D3  PF3  io8_ft
D4  PB5  io8_ft_i2c_v33
D5  PD3  io8_ft
D6  PA10  io8_ft_i2c
D7  PA13  io8_ft
D8  VDDIO2  power
E1  VSS  gnd
E2  PF2-NRST  ioreset_ft_v33
E3  PC0  io8_ft
E4  PA7  io8_ft_i2c
E5  PC7  io8_ft
E6  PA9  io8_ft_i2c
E7  PC6  io8_ft
E8  VSS  gnd
F1  PF0-OSC_IN  io8_ft
F2  PC1  io8_ft
F3  PA3  io8_ft
F4  PA6  io8_ft_i2c
F5  PB0  io8_ft
F6  PB14  io8_ft_i2c
F7  PB15  io8_ft
F8  PA8  io8_ft
G1  PF1-OSC_OUT  io8_ft
G2  PC2  io8_ft
G3  PA2  io8_ft_v33
G4  PA5  io8_ft
G5  PB1  io8_ft
G6  PB10  io8_ft_i2c
G7  PB12  io8_ft
G8  PB13  io8_ft_i2c
H1  PC3  io8_ft
H2  PA0  io8_ft_v33
H3  PA1  io8_ft
H4  PA4  io8_ft_v33
H5  PC4  io8_ft
H6  PC5  io8_ft_v33
H7  PB2  io8_ft
H8  PB11  io8_ft_i2c
[Package Model]   493-n-ufbga-5x5-64-240422
[Pin Mapping]   pulldown_ref   pullup_ref   | Comment
A1  gndio  vddio
A2  gndio  vddio
A3  gndio  vddio
A4  gndio  vddio
A5  gndio  vddio
A6  gndio  vddio2
A7  gndio  vddio2
A8  gndio  vddio2
B1  gndio  vddio
B2  gndio  vddio
B3  gndio  vddio
B4  gndio  vddio
B5  gndio  vddio
B6  gndio  vddio2
B7  gndio  vddio2
B8  gndio  vddio2
C1  gndio  vddio
C2  gndio  vddio
C3  gndio  vddio
C4  gndio  vddio
C5  gndio  vddio2
C6  gndio  vddio2
C7  gndio  vddio2
C8  gndio  vddio2
D1  nc  vddio
D2  nc  nc
D3  gndio  vddio
D4  gndio  vddio
D5  gndio  vddio2
D6  gndio  vddio2
D7  gndio  vddio2
D8  nc  vddio2
E1  gndio  nc
E2  gndio  vddio
E3  gndio  vddio
E4  gndio  vddio
E5  gndio  vddio2
E6  gndio  vddio2
E7  gndio  vddio2
E8  gndio  nc
F1  gndio  vddio
F2  gndio  vddio
F3  gndio  vddio
F4  gndio  vddio
F5  gndio  vddio
F6  gndio  vddio2
F7  gndio  vddio2
F8  gndio  vddio2
G1  gndio  vddio
G2  gndio  vddio
G3  gndio  vddio
G4  gndio  vddio
G5  gndio  vddio
G6  gndio  vddio
G7  gndio  vddio
G8  gndio  vddio2
H1  gndio  vddio
H2  gndio  vddio
H3  gndio  vddio
H4  gndio  vddio
H5  gndio  vddio
H6  gndio  vddio
H7  gndio  vddio
H8  gndio  vddio
|[Diff Pin]  inv_pin  vdiff  tdelay_typ  tdelay_min  tdelay_max
|B8  C8  NA  NA  NA  NA
[Model Selector] io8_ft
io8_ft_ls_3v3 "GPIO - 5V tolerant - low speed - 3.3V range"
io8_ft_ms_3v3 "GPIO - 5V tolerant - med speed - 3.3V range"
io8_ft_fs_3v3 "GPIO - 5V tolerant - fast speed - 3.3V range"
io8_ft_hs_3v3 "GPIO - 5V tolerant - high speed - 3.3V range"
io8_ft_ls_1v8 "GPIO - 5V tolerant - low speed - 1.8V range"
io8_ft_ms_1v8 "GPIO - 5V tolerant - med speed - 1.8V range"
io8_ft_fs_1v8 "GPIO - 5V tolerant - fast speed - 1.8V range"
io8_ft_hs_1v8 "GPIO - 5V tolerant - high speed - 1.8V range"
io8_ft_ls_1v2 "GPIO - 5V tolerant - low speed - 1.2V range"
io8_ft_ms_1v2 "GPIO - 5V tolerant - med speed - 1.2V range"
io8_ft_fs_1v2 "GPIO - 5V tolerant - fast speed - 1.2V range"
io8_ft_hs_1v2 "GPIO - 5V tolerant - high speed - 1.2V range"
[Model Selector] io8_ft_i2c
io8_ft_ls_3v3 "GPIO - 5V tolerant - low speed - 3.3V range"
io8_ft_ms_3v3 "GPIO - 5V tolerant - med speed - 3.3V range"
io8_ft_fs_3v3 "GPIO - 5V tolerant - fast speed - 3.3V range"
io8_ft_hs_3v3 "GPIO - 5V tolerant - high speed - 3.3V range"
io8_ft_ls_1v8 "GPIO - 5V tolerant - low speed - 1.8V range"
io8_ft_ms_1v8 "GPIO - 5V tolerant - med speed - 1.8V range"
io8_ft_fs_1v8 "GPIO - 5V tolerant - fast speed - 1.8V range"
io8_ft_hs_1v8 "GPIO - 5V tolerant - high speed - 1.8V range"
io8_ft_ls_1v2 "GPIO - 5V tolerant - low speed - 1.2V range"
io8_ft_ms_1v2 "GPIO - 5V tolerant - med speed - 1.2V range"
io8_ft_fs_1v2 "GPIO - 5V tolerant - fast speed - 1.2V range"
io8_ft_hs_1v2 "GPIO - 5V tolerant - high speed - 1.2V range"
io8_ft_i2c_ls_3v3 "GPIO with I2C open-drain - 5V tolerant - low speed - 3.3V range"
io8_ft_i2c_ms_3v3 "GPIO with I2C open-drain - 5V tolerant - med speed - 3.3V range"
io8_ft_i2c_fs_3v3 "GPIO with I2C open-drain - 5V tolerant - fast speed - 3.3V range"
io8_ft_i2c_hs_3v3 "GPIO with I2C open-drain - 5V tolerant - high speed - 3.3V range"
io8_ft_i2c_ls_1v8 "GPIO with I2C open-drain - 5V tolerant - low speed - 1.8V range"
io8_ft_i2c_ms_1v8 "GPIO with I2C open-drain - 5V tolerant - med speed - 1.8V range"
io8_ft_i2c_fs_1v8 "GPIO with I2C open-drain - 5V tolerant - fast speed - 1.8V range"
io8_ft_i2c_hs_1v8 "GPIO with I2C open-drain - 5V tolerant - high speed - 1.8V range"
io8_ft_i2c_ls_1v2 "GPIO with I2C open-drain - 5V tolerant - low speed - 1.2V range"
io8_ft_i2c_ms_1v2 "GPIO with I2C open-drain - 5V tolerant - med speed - 1.2V range"
io8_ft_i2c_fs_1v2 "GPIO with I2C open-drain - 5V tolerant - fast speed - 1.2V range"
io8_ft_i2c_hs_1v2 "GPIO with I2C open-drain - 5V tolerant - high speed - 1.2V range"
io8_ft_i2c_fmp_3v3 "GPIO with I2C fm+ open-drain - 5V tolerant - 3.3V range"
[Model Selector] io8_ft_i2c_v33
io8_ft_ls_3v3 "GPIO - 5V tolerant - low speed - 3.3V range"
io8_ft_ms_3v3 "GPIO - 5V tolerant - med speed - 3.3V range"
io8_ft_fs_3v3 "GPIO - 5V tolerant - fast speed - 3.3V range"
io8_ft_hs_3v3 "GPIO - 5V tolerant - high speed - 3.3V range"
io8_ft_ls_1v8 "GPIO - 5V tolerant - low speed - 1.8V range"
io8_ft_ms_1v8 "GPIO - 5V tolerant - med speed - 1.8V range"
io8_ft_fs_1v8 "GPIO - 5V tolerant - fast speed - 1.8V range"
io8_ft_hs_1v8 "GPIO - 5V tolerant - high speed - 1.8V range"
io8_ft_ls_1v2 "GPIO - 5V tolerant - low speed - 1.2V range"
io8_ft_ms_1v2 "GPIO - 5V tolerant - med speed - 1.2V range"
io8_ft_fs_1v2 "GPIO - 5V tolerant - fast speed - 1.2V range"
io8_ft_hs_1v2 "GPIO - 5V tolerant - high speed - 1.2V range"
io8_ft_i2c_v33_ls_3v3 "GPIO with I2C open-drain - 5V tolerant - low speed - 3.3V range"
io8_ft_i2c_v33_ms_3v3 "GPIO with I2C open-drain - 5V tolerant - med speed - 3.3V range"
io8_ft_i2c_v33_fs_3v3 "GPIO with I2C open-drain - 5V tolerant - fast speed - 3.3V range"
io8_ft_i2c_v33_hs_3v3 "GPIO with I2C open-drain - 5V tolerant - high speed - 3.3V range"
io8_ft_i2c_v33_ls_1v8 "GPIO with I2C open-drain - 5V tolerant - low speed - 1.8V range"
io8_ft_i2c_v33_ms_1v8 "GPIO with I2C open-drain - 5V tolerant - med speed - 1.8V range"
io8_ft_i2c_v33_fs_1v8 "GPIO with I2C open-drain - 5V tolerant - fast speed - 1.8V range"
io8_ft_i2c_v33_hs_1v8 "GPIO with I2C open-drain - 5V tolerant - high speed - 1.8V range"
io8_ft_i2c_v33_ls_1v2 "GPIO with I2C open-drain - 5V tolerant - low speed - 1.2V range"
io8_ft_i2c_v33_ms_1v2 "GPIO with I2C open-drain - 5V tolerant - med speed - 1.2V range"
io8_ft_i2c_v33_fs_1v2 "GPIO with I2C open-drain - 5V tolerant - fast speed - 1.2V range"
io8_ft_i2c_v33_hs_1v2 "GPIO with I2C open-drain - 5V tolerant - high speed - 1.2V range"
io8_ft_i2c_v33_fmp_3v3 "GPIO with I2C fm+ open-drain - 5V tolerant - 3.3V range"
[Model Selector] io8_ft_v33
io8_ft_v33_ls_3v3 "GPIO - 5V tolerant - low speed - 3.3V range"
io8_ft_v33_ms_3v3 "GPIO - 5V tolerant - med speed - 3.3V range"
io8_ft_v33_fs_3v3 "GPIO - 5V tolerant - fast speed - 3.3V range"
io8_ft_v33_hs_3v3 "GPIO - 5V tolerant - high speed - 3.3V range"
io8_ft_v33_ls_1v8 "GPIO - 5V tolerant - low speed - 1.8V range"
io8_ft_v33_ms_1v8 "GPIO - 5V tolerant - med speed - 1.8V range"
io8_ft_v33_fs_1v8 "GPIO - 5V tolerant - fast speed - 1.8V range"
io8_ft_v33_hs_1v8 "GPIO - 5V tolerant - high speed - 1.8V range"
io8_ft_v33_ls_1v2 "GPIO - 5V tolerant - low speed - 1.2V range"
io8_ft_v33_ms_1v2 "GPIO - 5V tolerant - med speed - 1.2V range"
io8_ft_v33_fs_1v2 "GPIO - 5V tolerant - fast speed - 1.2V range"
io8_ft_v33_hs_1v2 "GPIO - 5V tolerant - high speed - 1.2V range"
[Model Selector] io8usb_ft_i2c_phy
io8_ft_ls_3v3 "GPIO - 5V tolerant - low speed - 3.3V range"
io8_ft_ms_3v3 "GPIO - 5V tolerant - med speed - 3.3V range"
io8_ft_fs_3v3 "GPIO - 5V tolerant - fast speed - 3.3V range"
io8_ft_hs_3v3 "GPIO - 5V tolerant - high speed - 3.3V range"
io8_ft_ls_1v8 "GPIO - 5V tolerant - low speed - 1.8V range"
io8_ft_ms_1v8 "GPIO - 5V tolerant - med speed - 1.8V range"
io8_ft_fs_1v8 "GPIO - 5V tolerant - fast speed - 1.8V range"
io8_ft_hs_1v8 "GPIO - 5V tolerant - high speed - 1.8V range"
io8_ft_ls_1v2 "GPIO - 5V tolerant - low speed - 1.2V range"
io8_ft_ms_1v2 "GPIO - 5V tolerant - med speed - 1.2V range"
io8_ft_fs_1v2 "GPIO - 5V tolerant - fast speed - 1.2V range"
io8_ft_hs_1v2 "GPIO - 5V tolerant - high speed - 1.2V range"
io8_ft_i2c_ls_3v3 "GPIO with I2C open-drain - 5V tolerant - low speed - 3.3V range"
io8_ft_i2c_ms_3v3 "GPIO with I2C open-drain - 5V tolerant - med speed - 3.3V range"
io8_ft_i2c_fs_3v3 "GPIO with I2C open-drain - 5V tolerant - fast speed - 3.3V range"
io8_ft_i2c_hs_3v3 "GPIO with I2C open-drain - 5V tolerant - high speed - 3.3V range"
io8_ft_i2c_ls_1v8 "GPIO with I2C open-drain - 5V tolerant - low speed - 1.8V range"
io8_ft_i2c_ms_1v8 "GPIO with I2C open-drain - 5V tolerant - med speed - 1.8V range"
io8_ft_i2c_fs_1v8 "GPIO with I2C open-drain - 5V tolerant - fast speed - 1.8V range"
io8_ft_i2c_hs_1v8 "GPIO with I2C open-drain - 5V tolerant - high speed - 1.8V range"
io8_ft_i2c_ls_1v2 "GPIO with I2C open-drain - 5V tolerant - low speed - 1.2V range"
io8_ft_i2c_ms_1v2 "GPIO with I2C open-drain - 5V tolerant - med speed - 1.2V range"
io8_ft_i2c_fs_1v2 "GPIO with I2C open-drain - 5V tolerant - fast speed - 1.2V range"
io8_ft_i2c_hs_1v2 "GPIO with I2C open-drain - 5V tolerant - high speed - 1.2V range"
io8_ft_i2c_fmp_3v3 "GPIO with I2C fm+ open-drain - 5V tolerant - 3.3V range"
io8usb_ft_phy_fs_3v3   "USB full speed"
io8usb_ft_phy_ls_3v3   "USB low speed"
[Model Selector] ioreset_ft_v33
io8_ft_v33_ls_3v3 "GPIO - 5V tolerant - low speed - 3.3V range"
io8_ft_v33_ms_3v3 "GPIO - 5V tolerant - med speed - 3.3V range"
io8_ft_v33_fs_3v3 "GPIO - 5V tolerant - fast speed - 3.3V range"
io8_ft_v33_hs_3v3 "GPIO - 5V tolerant - high speed - 3.3V range"
io8_ft_v33_ls_1v8 "GPIO - 5V tolerant - low speed - 1.8V range"
io8_ft_v33_ms_1v8 "GPIO - 5V tolerant - med speed - 1.8V range"
io8_ft_v33_fs_1v8 "GPIO - 5V tolerant - fast speed - 1.8V range"
io8_ft_v33_hs_1v8 "GPIO - 5V tolerant - high speed - 1.8V range"
io8_ft_v33_ls_1v2 "GPIO - 5V tolerant - low speed - 1.2V range"
io8_ft_v33_ms_1v2 "GPIO - 5V tolerant - med speed - 1.2V range"
io8_ft_v33_fs_1v2 "GPIO - 5V tolerant - fast speed - 1.2V range"
io8_ft_v33_hs_1v2 "GPIO - 5V tolerant - high speed - 1.2V range"
ioreset_ft_v33_1v2   "Reset PAD. 5V tolerant. 1.2V range"
ioreset_ft_v33_1v8   "Reset PAD. 5V tolerant. 1.8V range"
ioreset_ft_v33_3v3   "Reset PAD. 5V tolerant. 3.3V range"
[Define Package Model]  493-n-ufbga-5x5-64-240422
[Manufacturer]  unknown
[OEM]  unknown
[Description]  unknown
[Number Of Pins]  64
[Pin Numbers]
| Pin Name Terminal   Net Name   Starting Node   Ending Node
H2 | PA0
H3 | PA1
G3 | PA2
F3 | PA3
H4 | PA4
G4 | PA5
F4 | PA6
E4 | PA7
F8 | PA8
E6 | PA9
D6 | PA10
C8 | PA11
B8 | PA12
D7 | PA13
C7 | PA14-BOOT0
C6 | PA15
F5 | PB0
G5 | PB1
H7 | PB2
B4 | PB3
C4 | PB4
D4 | PB5
A4 | PB6
A3 | PB7
B3 | PB8
C3 | PB9
G6 | PB10
H8 | PB11
G7 | PB12
G8 | PB13
F6 | PB14
F7 | PB15
E3 | PC0
F2 | PC1
G2 | PC2
H1 | PC3
H5 | PC4
H6 | PC5
E7 | PC6
E5 | PC7
A8 | PC8
B7 | PC9
A2 | PC10
A1 | PC11
B2 | PC12
C2 | PC13
C1 | PC14-OSCX_IN
B1 | PC15-OSCX_OUT
A7 | PD0
B6 | PD1
A6 | PD2
D5 | PD3
C5 | PD4
B5 | PD5
A5 | PD6
F1 | PF0-OSC_IN
G1 | PF1-OSC_OUT
E2 | PF2-NRST
D3 | PF3
D1 | VDD
D8 | VDDIO2
D2 | VREFP
E8 | VSS
E1 | VSS
[Model Data]
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[End Model Data]
[End Package Model]
|End [Component]
| Models and submodels in the file (55): io8_ft_fs_1v2 (I/O), io8_ft_fs_1v8 (I/O), io8_ft_fs_3v3 (I/O), io8_ft_hs_1v2 (I/O), io8_ft_hs_1v8 (I/O), io8_ft_hs_3v3 (I/O), io8_ft_i2c_fmp_3v3 (I/O_open_drain), io8_ft_i2c_fs_1v2 (I/O_open_drain), io8_ft_i2c_fs_1v8 (I/O_open_drain), io8_ft_i2c_fs_3v3 (I/O_open_drain), io8_ft_i2c_hs_1v2 (I/O_open_drain), io8_ft_i2c_hs_1v8 (I/O_open_drain), io8_ft_i2c_hs_3v3 (I/O_open_drain), io8_ft_i2c_ls_1v2 (I/O_open_drain), io8_ft_i2c_ls_1v8 (I/O_open_drain), io8_ft_i2c_ls_3v3 (I/O_open_drain), io8_ft_i2c_ms_1v2 (I/O_open_drain), io8_ft_i2c_ms_1v8 (I/O_open_drain), io8_ft_i2c_ms_3v3 (I/O_open_drain), io8_ft_i2c_v33_fmp_3v3 (I/O_open_drain), io8_ft_i2c_v33_fs_1v2 (I/O_open_drain), io8_ft_i2c_v33_fs_1v8 (I/O_open_drain), io8_ft_i2c_v33_fs_3v3 (I/O_open_drain), io8_ft_i2c_v33_hs_1v2 (I/O_open_drain), io8_ft_i2c_v33_hs_1v8 (I/O_open_drain), io8_ft_i2c_v33_hs_3v3 (I/O_open_drain), io8_ft_i2c_v33_ls_1v2 (I/O_open_drain), io8_ft_i2c_v33_ls_1v8 (I/O_open_drain), io8_ft_i2c_v33_ls_3v3 (I/O_open_drain), io8_ft_i2c_v33_ms_1v2 (I/O_open_drain), io8_ft_i2c_v33_ms_1v8 (I/O_open_drain), io8_ft_i2c_v33_ms_3v3 (I/O_open_drain), io8_ft_ls_1v2 (I/O), io8_ft_ls_1v8 (I/O), io8_ft_ls_3v3 (I/O), io8_ft_ms_1v2 (I/O), io8_ft_ms_1v8 (I/O), io8_ft_ms_3v3 (I/O), io8_ft_v33_fs_1v2 (I/O), io8_ft_v33_fs_1v8 (I/O), io8_ft_v33_fs_3v3 (I/O), io8_ft_v33_hs_1v2 (I/O), io8_ft_v33_hs_1v8 (I/O), io8_ft_v33_hs_3v3 (I/O), io8_ft_v33_ls_1v2 (I/O), io8_ft_v33_ls_1v8 (I/O), io8_ft_v33_ls_3v3 (I/O), io8_ft_v33_ms_1v2 (I/O), io8_ft_v33_ms_1v8 (I/O), io8_ft_v33_ms_3v3 (I/O), io8usb_ft_phy_fs_3v3 (I/O), io8usb_ft_phy_ls_3v3 (I/O), ioreset_ft_v33_1v2 (Input), ioreset_ft_v33_1v8 (Input), ioreset_ft_v33_3v3 (Input)
