| IBIS file stm32c071_lqfp64_n.ibs
[IBIS ver] 4.2
[File name] stm32c071_lqfp64_n.ibs
[File Rev] 0.1
[Date] 27-05-2024
[Source] Data Created at STMicroelectronics
[Notes]  File originated from ELDO simulations.
[Disclaimer]  This information is for modeling purpose only and is
   not guaranteed. The information is subject to change without
   notice.
[Copyright] Copyright 2024 STMicroelectronics Inc.
|   Component stm32c071_lqfp64_n
[Component] stm32c071_lqfp64_n
[Manufacturer] STMicroelectronics
[Package]
| variable   typ   min   max
R_pkg  0  NA  NA
L_pkg  0  NA  NA
C_pkg  0  NA  NA
[Pin]   signal_name   model_name
1  PC11  io8_ft
2  PC12  io8_ft
3  PC13  io8_ft_v33
4  PC14-OSCX_IN  io8_ft_i2c
5  PC15-OSCX_OUT  io8_ft
6  PF3  io8_ft
7  VREFP  nc
8  VDD  power
9  VSS  gnd
10  PF0-OSC_IN  io8_ft
11  PF1-OSC_OUT  io8_ft
12  PF2-NRST  ioreset_ft_v33
13  PC0  io8_ft
14  PC1  io8_ft
15  PC2  io8_ft
16  PC3  io8_ft
17  PA0  io8_ft_v33
18  PA1  io8_ft
19  PA2  io8_ft_v33
20  PA3  io8_ft
21  PA4  io8_ft_v33
22  PA5  io8_ft
23  PA6  io8_ft_i2c
24  PA7  io8_ft_i2c
25  PC4  io8_ft
26  PC5  io8_ft_v33
27  PB0  io8_ft
28  PB1  io8_ft
29  PB2  io8_ft
30  PB10  io8_ft_i2c
31  PB11  io8_ft_i2c
32  PB12  io8_ft
33  PB13  io8_ft_i2c
34  PB14  io8_ft_i2c
35  PB15  io8_ft
36  PA8  io8_ft
37  PA9  io8_ft_i2c
38  PC6  io8_ft
39  PC7  io8_ft
40  VSS  gnd
41  VDDIO2  power
42  PA10  io8_ft_i2c
43  PA11  io8usb_ft_i2c_phy
44  PA12  io8usb_ft_i2c_phy
45  PA13  io8_ft
46  PA14-BOOT0  io8_ft_v33
47  PA15  io8_ft
48  PC8  io8_ft
49  PC9  io8_ft
50  PD0  io8_ft
51  PD1  io8_ft
52  PD2  io8_ft
53  PD3  io8_ft
54  PD4  io8_ft
55  PD5  io8_ft
56  PD6  io8_ft
57  PB3  io8_ft_i2c
58  PB4  io8_ft_i2c
59  PB5  io8_ft_i2c_v33
60  PB6  io8_ft_i2c_v33
61  PB7  io8_ft_i2c
62  PB8  io8_ft_i2c
63  PB9  io8_ft_i2c
64  PC10  io8_ft
[Package Model]   493-lqfp-10x10-64-n-240419
[Pin Mapping]   pulldown_ref   pullup_ref   | Comment
1  gndio  vddio
2  gndio  vddio
3  gndio  vddio
4  gndio  vddio
5  gndio  vddio
6  gndio  vddio
7  nc  nc
8  nc  vddio
9  gndio  nc
10  gndio  vddio
11  gndio  vddio
12  gndio  vddio
13  gndio  vddio
14  gndio  vddio
15  gndio  vddio
16  gndio  vddio
17  gndio  vddio
18  gndio  vddio
19  gndio  vddio
20  gndio  vddio
21  gndio  vddio
22  gndio  vddio
23  gndio  vddio
24  gndio  vddio
25  gndio  vddio
26  gndio  vddio
27  gndio  vddio
28  gndio  vddio
29  gndio  vddio
30  gndio  vddio
31  gndio  vddio
32  gndio  vddio
33  gndio  vddio2
34  gndio  vddio2
35  gndio  vddio2
36  gndio  vddio2
37  gndio  vddio2
38  gndio  vddio2
39  gndio  vddio2
40  gndio  nc
41  nc  vddio2
42  gndio  vddio2
43  gndio  vddio2
44  gndio  vddio2
45  gndio  vddio2
46  gndio  vddio2
47  gndio  vddio2
48  gndio  vddio2
49  gndio  vddio2
50  gndio  vddio2
51  gndio  vddio2
52  gndio  vddio2
53  gndio  vddio2
54  gndio  vddio2
55  gndio  vddio
56  gndio  vddio
57  gndio  vddio
58  gndio  vddio
59  gndio  vddio
60  gndio  vddio
61  gndio  vddio
62  gndio  vddio
63  gndio  vddio
64  gndio  vddio
|[Diff Pin]  inv_pin  vdiff  tdelay_typ  tdelay_min  tdelay_max
|44  43  NA  NA  NA  NA
[Model Selector] io8_ft
io8_ft_ls_3v3 "GPIO - 5V tolerant - low speed - 3.3V range"
io8_ft_ms_3v3 "GPIO - 5V tolerant - med speed - 3.3V range"
io8_ft_fs_3v3 "GPIO - 5V tolerant - fast speed - 3.3V range"
io8_ft_hs_3v3 "GPIO - 5V tolerant - high speed - 3.3V range"
io8_ft_ls_1v8 "GPIO - 5V tolerant - low speed - 1.8V range"
io8_ft_ms_1v8 "GPIO - 5V tolerant - med speed - 1.8V range"
io8_ft_fs_1v8 "GPIO - 5V tolerant - fast speed - 1.8V range"
io8_ft_hs_1v8 "GPIO - 5V tolerant - high speed - 1.8V range"
io8_ft_ls_1v2 "GPIO - 5V tolerant - low speed - 1.2V range"
io8_ft_ms_1v2 "GPIO - 5V tolerant - med speed - 1.2V range"
io8_ft_fs_1v2 "GPIO - 5V tolerant - fast speed - 1.2V range"
io8_ft_hs_1v2 "GPIO - 5V tolerant - high speed - 1.2V range"
[Model Selector] io8_ft_i2c
io8_ft_ls_3v3 "GPIO - 5V tolerant - low speed - 3.3V range"
io8_ft_ms_3v3 "GPIO - 5V tolerant - med speed - 3.3V range"
io8_ft_fs_3v3 "GPIO - 5V tolerant - fast speed - 3.3V range"
io8_ft_hs_3v3 "GPIO - 5V tolerant - high speed - 3.3V range"
io8_ft_ls_1v8 "GPIO - 5V tolerant - low speed - 1.8V range"
io8_ft_ms_1v8 "GPIO - 5V tolerant - med speed - 1.8V range"
io8_ft_fs_1v8 "GPIO - 5V tolerant - fast speed - 1.8V range"
io8_ft_hs_1v8 "GPIO - 5V tolerant - high speed - 1.8V range"
io8_ft_ls_1v2 "GPIO - 5V tolerant - low speed - 1.2V range"
io8_ft_ms_1v2 "GPIO - 5V tolerant - med speed - 1.2V range"
io8_ft_fs_1v2 "GPIO - 5V tolerant - fast speed - 1.2V range"
io8_ft_hs_1v2 "GPIO - 5V tolerant - high speed - 1.2V range"
io8_ft_i2c_ls_3v3 "GPIO with I2C open-drain - 5V tolerant - low speed - 3.3V range"
io8_ft_i2c_ms_3v3 "GPIO with I2C open-drain - 5V tolerant - med speed - 3.3V range"
io8_ft_i2c_fs_3v3 "GPIO with I2C open-drain - 5V tolerant - fast speed - 3.3V range"
io8_ft_i2c_hs_3v3 "GPIO with I2C open-drain - 5V tolerant - high speed - 3.3V range"
io8_ft_i2c_ls_1v8 "GPIO with I2C open-drain - 5V tolerant - low speed - 1.8V range"
io8_ft_i2c_ms_1v8 "GPIO with I2C open-drain - 5V tolerant - med speed - 1.8V range"
io8_ft_i2c_fs_1v8 "GPIO with I2C open-drain - 5V tolerant - fast speed - 1.8V range"
io8_ft_i2c_hs_1v8 "GPIO with I2C open-drain - 5V tolerant - high speed - 1.8V range"
io8_ft_i2c_ls_1v2 "GPIO with I2C open-drain - 5V tolerant - low speed - 1.2V range"
io8_ft_i2c_ms_1v2 "GPIO with I2C open-drain - 5V tolerant - med speed - 1.2V range"
io8_ft_i2c_fs_1v2 "GPIO with I2C open-drain - 5V tolerant - fast speed - 1.2V range"
io8_ft_i2c_hs_1v2 "GPIO with I2C open-drain - 5V tolerant - high speed - 1.2V range"
io8_ft_i2c_fmp_3v3 "GPIO with I2C fm+ open-drain - 5V tolerant - 3.3V range"
[Model Selector] io8_ft_i2c_v33
io8_ft_ls_3v3 "GPIO - 5V tolerant - low speed - 3.3V range"
io8_ft_ms_3v3 "GPIO - 5V tolerant - med speed - 3.3V range"
io8_ft_fs_3v3 "GPIO - 5V tolerant - fast speed - 3.3V range"
io8_ft_hs_3v3 "GPIO - 5V tolerant - high speed - 3.3V range"
io8_ft_ls_1v8 "GPIO - 5V tolerant - low speed - 1.8V range"
io8_ft_ms_1v8 "GPIO - 5V tolerant - med speed - 1.8V range"
io8_ft_fs_1v8 "GPIO - 5V tolerant - fast speed - 1.8V range"
io8_ft_hs_1v8 "GPIO - 5V tolerant - high speed - 1.8V range"
io8_ft_ls_1v2 "GPIO - 5V tolerant - low speed - 1.2V range"
io8_ft_ms_1v2 "GPIO - 5V tolerant - med speed - 1.2V range"
io8_ft_fs_1v2 "GPIO - 5V tolerant - fast speed - 1.2V range"
io8_ft_hs_1v2 "GPIO - 5V tolerant - high speed - 1.2V range"
io8_ft_i2c_v33_ls_3v3 "GPIO with I2C open-drain - 5V tolerant - low speed - 3.3V range"
io8_ft_i2c_v33_ms_3v3 "GPIO with I2C open-drain - 5V tolerant - med speed - 3.3V range"
io8_ft_i2c_v33_fs_3v3 "GPIO with I2C open-drain - 5V tolerant - fast speed - 3.3V range"
io8_ft_i2c_v33_hs_3v3 "GPIO with I2C open-drain - 5V tolerant - high speed - 3.3V range"
io8_ft_i2c_v33_ls_1v8 "GPIO with I2C open-drain - 5V tolerant - low speed - 1.8V range"
io8_ft_i2c_v33_ms_1v8 "GPIO with I2C open-drain - 5V tolerant - med speed - 1.8V range"
io8_ft_i2c_v33_fs_1v8 "GPIO with I2C open-drain - 5V tolerant - fast speed - 1.8V range"
io8_ft_i2c_v33_hs_1v8 "GPIO with I2C open-drain - 5V tolerant - high speed - 1.8V range"
io8_ft_i2c_v33_ls_1v2 "GPIO with I2C open-drain - 5V tolerant - low speed - 1.2V range"
io8_ft_i2c_v33_ms_1v2 "GPIO with I2C open-drain - 5V tolerant - med speed - 1.2V range"
io8_ft_i2c_v33_fs_1v2 "GPIO with I2C open-drain - 5V tolerant - fast speed - 1.2V range"
io8_ft_i2c_v33_hs_1v2 "GPIO with I2C open-drain - 5V tolerant - high speed - 1.2V range"
io8_ft_i2c_v33_fmp_3v3 "GPIO with I2C fm+ open-drain - 5V tolerant - 3.3V range"
[Model Selector] io8_ft_v33
io8_ft_v33_ls_3v3 "GPIO - 5V tolerant - low speed - 3.3V range"
io8_ft_v33_ms_3v3 "GPIO - 5V tolerant - med speed - 3.3V range"
io8_ft_v33_fs_3v3 "GPIO - 5V tolerant - fast speed - 3.3V range"
io8_ft_v33_hs_3v3 "GPIO - 5V tolerant - high speed - 3.3V range"
io8_ft_v33_ls_1v8 "GPIO - 5V tolerant - low speed - 1.8V range"
io8_ft_v33_ms_1v8 "GPIO - 5V tolerant - med speed - 1.8V range"
io8_ft_v33_fs_1v8 "GPIO - 5V tolerant - fast speed - 1.8V range"
io8_ft_v33_hs_1v8 "GPIO - 5V tolerant - high speed - 1.8V range"
io8_ft_v33_ls_1v2 "GPIO - 5V tolerant - low speed - 1.2V range"
io8_ft_v33_ms_1v2 "GPIO - 5V tolerant - med speed - 1.2V range"
io8_ft_v33_fs_1v2 "GPIO - 5V tolerant - fast speed - 1.2V range"
io8_ft_v33_hs_1v2 "GPIO - 5V tolerant - high speed - 1.2V range"
[Model Selector] io8usb_ft_i2c_phy
io8_ft_ls_3v3 "GPIO - 5V tolerant - low speed - 3.3V range"
io8_ft_ms_3v3 "GPIO - 5V tolerant - med speed - 3.3V range"
io8_ft_fs_3v3 "GPIO - 5V tolerant - fast speed - 3.3V range"
io8_ft_hs_3v3 "GPIO - 5V tolerant - high speed - 3.3V range"
io8_ft_ls_1v8 "GPIO - 5V tolerant - low speed - 1.8V range"
io8_ft_ms_1v8 "GPIO - 5V tolerant - med speed - 1.8V range"
io8_ft_fs_1v8 "GPIO - 5V tolerant - fast speed - 1.8V range"
io8_ft_hs_1v8 "GPIO - 5V tolerant - high speed - 1.8V range"
io8_ft_ls_1v2 "GPIO - 5V tolerant - low speed - 1.2V range"
io8_ft_ms_1v2 "GPIO - 5V tolerant - med speed - 1.2V range"
io8_ft_fs_1v2 "GPIO - 5V tolerant - fast speed - 1.2V range"
io8_ft_hs_1v2 "GPIO - 5V tolerant - high speed - 1.2V range"
io8_ft_i2c_ls_3v3 "GPIO with I2C open-drain - 5V tolerant - low speed - 3.3V range"
io8_ft_i2c_ms_3v3 "GPIO with I2C open-drain - 5V tolerant - med speed - 3.3V range"
io8_ft_i2c_fs_3v3 "GPIO with I2C open-drain - 5V tolerant - fast speed - 3.3V range"
io8_ft_i2c_hs_3v3 "GPIO with I2C open-drain - 5V tolerant - high speed - 3.3V range"
io8_ft_i2c_ls_1v8 "GPIO with I2C open-drain - 5V tolerant - low speed - 1.8V range"
io8_ft_i2c_ms_1v8 "GPIO with I2C open-drain - 5V tolerant - med speed - 1.8V range"
io8_ft_i2c_fs_1v8 "GPIO with I2C open-drain - 5V tolerant - fast speed - 1.8V range"
io8_ft_i2c_hs_1v8 "GPIO with I2C open-drain - 5V tolerant - high speed - 1.8V range"
io8_ft_i2c_ls_1v2 "GPIO with I2C open-drain - 5V tolerant - low speed - 1.2V range"
io8_ft_i2c_ms_1v2 "GPIO with I2C open-drain - 5V tolerant - med speed - 1.2V range"
io8_ft_i2c_fs_1v2 "GPIO with I2C open-drain - 5V tolerant - fast speed - 1.2V range"
io8_ft_i2c_hs_1v2 "GPIO with I2C open-drain - 5V tolerant - high speed - 1.2V range"
io8_ft_i2c_fmp_3v3 "GPIO with I2C fm+ open-drain - 5V tolerant - 3.3V range"
io8usb_ft_phy_fs_3v3   "USB full speed"
io8usb_ft_phy_ls_3v3   "USB low speed"
[Model Selector] ioreset_ft_v33
io8_ft_v33_ls_3v3 "GPIO - 5V tolerant - low speed - 3.3V range"
io8_ft_v33_ms_3v3 "GPIO - 5V tolerant - med speed - 3.3V range"
io8_ft_v33_fs_3v3 "GPIO - 5V tolerant - fast speed - 3.3V range"
io8_ft_v33_hs_3v3 "GPIO - 5V tolerant - high speed - 3.3V range"
io8_ft_v33_ls_1v8 "GPIO - 5V tolerant - low speed - 1.8V range"
io8_ft_v33_ms_1v8 "GPIO - 5V tolerant - med speed - 1.8V range"
io8_ft_v33_fs_1v8 "GPIO - 5V tolerant - fast speed - 1.8V range"
io8_ft_v33_hs_1v8 "GPIO - 5V tolerant - high speed - 1.8V range"
io8_ft_v33_ls_1v2 "GPIO - 5V tolerant - low speed - 1.2V range"
io8_ft_v33_ms_1v2 "GPIO - 5V tolerant - med speed - 1.2V range"
io8_ft_v33_fs_1v2 "GPIO - 5V tolerant - fast speed - 1.2V range"
io8_ft_v33_hs_1v2 "GPIO - 5V tolerant - high speed - 1.2V range"
ioreset_ft_v33_1v2   "Reset PAD. 5V tolerant. 1.2V range"
ioreset_ft_v33_1v8   "Reset PAD. 5V tolerant. 1.8V range"
ioreset_ft_v33_3v3   "Reset PAD. 5V tolerant. 3.3V range"
[Define Package Model]  493-lqfp-10x10-64-n-240419
[Manufacturer]  Unknown
[OEM]  Unknown
[Description]  None
[Number Of Pins]  64
[Pin Numbers]
| Pin Num   Terminal Name
17 | PA0
18 | PA1
19 | PA2
20 | PA3
21 | PA4
22 | PA5
23 | PA6
24 | PA7
36 | PA8
37 | PA9
42 | PA10
43 | PA11
44 | PA12
45 | PA13
46 | PA14-BOOT0
47 | PA15
27 | PB0
28 | PB1
29 | PB2
57 | PB3
58 | PB4
59 | PB5
60 | PB6
61 | PB7
62 | PB8
63 | PB9
30 | PB10
31 | PB11
32 | PB12
33 | PB13
34 | PB14
35 | PB15
13 | PC0
14 | PC1
15 | PC2
16 | PC3
25 | PC4
26 | PC5
38 | PC6
39 | PC7
48 | PC8
49 | PC9
64 | PC10
1 | PC11
2 | PC12
3 | PC13
4 | PC14-OSCX_IN
5 | PC15-OSCX_OUT
50 | PD0
51 | PD1
52 | PD2
53 | PD3
54 | PD4
55 | PD5
56 | PD6
10 | PF0-OSC_IN
11 | PF1-OSC_OUT
12 | PF2-NRST
6 | PF3
8 | VDD
41 | VDDIO2
7 | VREFP
9 | VSS
40 | VSS
[Model Data]
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[End Model Data]
[End Package Model]
|End [Component]
| Models and submodels in the file (55): io8_ft_fs_1v2 (I/O), io8_ft_fs_1v8 (I/O), io8_ft_fs_3v3 (I/O), io8_ft_hs_1v2 (I/O), io8_ft_hs_1v8 (I/O), io8_ft_hs_3v3 (I/O), io8_ft_i2c_fmp_3v3 (I/O_open_drain), io8_ft_i2c_fs_1v2 (I/O_open_drain), io8_ft_i2c_fs_1v8 (I/O_open_drain), io8_ft_i2c_fs_3v3 (I/O_open_drain), io8_ft_i2c_hs_1v2 (I/O_open_drain), io8_ft_i2c_hs_1v8 (I/O_open_drain), io8_ft_i2c_hs_3v3 (I/O_open_drain), io8_ft_i2c_ls_1v2 (I/O_open_drain), io8_ft_i2c_ls_1v8 (I/O_open_drain), io8_ft_i2c_ls_3v3 (I/O_open_drain), io8_ft_i2c_ms_1v2 (I/O_open_drain), io8_ft_i2c_ms_1v8 (I/O_open_drain), io8_ft_i2c_ms_3v3 (I/O_open_drain), io8_ft_i2c_v33_fmp_3v3 (I/O_open_drain), io8_ft_i2c_v33_fs_1v2 (I/O_open_drain), io8_ft_i2c_v33_fs_1v8 (I/O_open_drain), io8_ft_i2c_v33_fs_3v3 (I/O_open_drain), io8_ft_i2c_v33_hs_1v2 (I/O_open_drain), io8_ft_i2c_v33_hs_1v8 (I/O_open_drain), io8_ft_i2c_v33_hs_3v3 (I/O_open_drain), io8_ft_i2c_v33_ls_1v2 (I/O_open_drain), io8_ft_i2c_v33_ls_1v8 (I/O_open_drain), io8_ft_i2c_v33_ls_3v3 (I/O_open_drain), io8_ft_i2c_v33_ms_1v2 (I/O_open_drain), io8_ft_i2c_v33_ms_1v8 (I/O_open_drain), io8_ft_i2c_v33_ms_3v3 (I/O_open_drain), io8_ft_ls_1v2 (I/O), io8_ft_ls_1v8 (I/O), io8_ft_ls_3v3 (I/O), io8_ft_ms_1v2 (I/O), io8_ft_ms_1v8 (I/O), io8_ft_ms_3v3 (I/O), io8_ft_v33_fs_1v2 (I/O), io8_ft_v33_fs_1v8 (I/O), io8_ft_v33_fs_3v3 (I/O), io8_ft_v33_hs_1v2 (I/O), io8_ft_v33_hs_1v8 (I/O), io8_ft_v33_hs_3v3 (I/O), io8_ft_v33_ls_1v2 (I/O), io8_ft_v33_ls_1v8 (I/O), io8_ft_v33_ls_3v3 (I/O), io8_ft_v33_ms_1v2 (I/O), io8_ft_v33_ms_1v8 (I/O), io8_ft_v33_ms_3v3 (I/O), io8usb_ft_phy_fs_3v3 (I/O), io8usb_ft_phy_ls_3v3 (I/O), ioreset_ft_v33_1v2 (Input), ioreset_ft_v33_1v8 (Input), ioreset_ft_v33_3v3 (Input)
