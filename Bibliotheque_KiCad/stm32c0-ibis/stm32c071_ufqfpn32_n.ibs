| IBIS file stm32c071_ufqfpn32_n.ibs
[IBIS ver] 4.2
[File name] stm32c071_ufqfpn32_n.ibs
[File Rev] 0.1
[Date] 27-05-2024
[Source] Data Created at STMicroelectronics
[Notes]  File originated from ELDO simulations.
[Disclaimer]  This information is for modeling purpose only and is
   not guaranteed. The information is subject to change without
   notice.
[Copyright] Copyright 2024 STMicroelectronics Inc.
|   Component stm32c071_ufqfpn32_n
[Component] stm32c071_ufqfpn32_n
[Manufacturer] STMicroelectronics
[Package]
| variable   typ   min   max
R_pkg  0  NA  NA
L_pkg  0  NA  NA
C_pkg  0  NA  NA
[Pin]   signal_name   model_name
1  PB9  io8_ft_i2c
2  PC14-OSCX_IN  io8_ft_i2c
3  PC15-OSCX_OUT  io8_ft
4  VDD  power
5  VSS  gnd
6  PF2-NRST  ioreset_ft_v33
7  PA0  io8_ft_v33
8  PA1  io8_ft
9  PA2  io8_ft_v33
10  PA3  io8_ft
11  PA4  io8_ft_v33
12  PA5  io8_ft
13  PA6  io8_ft_i2c
14  PA7  io8_ft_i2c
15  PB0  io8_ft
16  PB1  io8_ft
17  PB2  io8_ft
18  PA8  io8_ft
19  PA9  io8_ft_i2c
20  VDDIO2  power
21  PA10  io8_ft_i2c
22  PA11  io8usb_ft_i2c_phy
23  PA12  io8usb_ft_i2c_phy
24  PA13  io8_ft
25  PA14-BOOT0  io8_ft_v33
26  PA15  io8_ft
27  PB3  io8_ft_i2c
28  PB4  io8_ft_i2c
29  PB5  io8_ft_i2c_v33
30  PB6  io8_ft_i2c_v33
31  PB7  io8_ft_i2c
32  PB8  io8_ft_i2c
[Package Model]   493-uqfn-5x5-32-n-240422
[Pin Mapping]   pulldown_ref   pullup_ref   | Comment
1  gndio  vddio
2  gndio  vddio
3  gndio  vddio
4  nc  vddio
5  gndio  nc
6  gndio  vddio
7  gndio  vddio
8  gndio  vddio
9  gndio  vddio
10  gndio  vddio
11  gndio  vddio
12  gndio  vddio
13  gndio  vddio
14  gndio  vddio
15  gndio  vddio
16  gndio  vddio
17  gndio  vddio
18  gndio  vddio2
19  gndio  vddio2
20  nc  vddio2
21  gndio  vddio2
22  gndio  vddio2
23  gndio  vddio2
24  gndio  vddio2
25  gndio  vddio2
26  gndio  vddio2
27  gndio  vddio
28  gndio  vddio
29  gndio  vddio
30  gndio  vddio
31  gndio  vddio
32  gndio  vddio
|[Diff Pin]  inv_pin  vdiff  tdelay_typ  tdelay_min  tdelay_max
|23  22  NA  NA  NA  NA
[Model Selector] io8_ft
io8_ft_ls_3v3 "GPIO - 5V tolerant - low speed - 3.3V range"
io8_ft_ms_3v3 "GPIO - 5V tolerant - med speed - 3.3V range"
io8_ft_fs_3v3 "GPIO - 5V tolerant - fast speed - 3.3V range"
io8_ft_hs_3v3 "GPIO - 5V tolerant - high speed - 3.3V range"
io8_ft_ls_1v8 "GPIO - 5V tolerant - low speed - 1.8V range"
io8_ft_ms_1v8 "GPIO - 5V tolerant - med speed - 1.8V range"
io8_ft_fs_1v8 "GPIO - 5V tolerant - fast speed - 1.8V range"
io8_ft_hs_1v8 "GPIO - 5V tolerant - high speed - 1.8V range"
io8_ft_ls_1v2 "GPIO - 5V tolerant - low speed - 1.2V range"
io8_ft_ms_1v2 "GPIO - 5V tolerant - med speed - 1.2V range"
io8_ft_fs_1v2 "GPIO - 5V tolerant - fast speed - 1.2V range"
io8_ft_hs_1v2 "GPIO - 5V tolerant - high speed - 1.2V range"
[Model Selector] io8_ft_i2c
io8_ft_ls_3v3 "GPIO - 5V tolerant - low speed - 3.3V range"
io8_ft_ms_3v3 "GPIO - 5V tolerant - med speed - 3.3V range"
io8_ft_fs_3v3 "GPIO - 5V tolerant - fast speed - 3.3V range"
io8_ft_hs_3v3 "GPIO - 5V tolerant - high speed - 3.3V range"
io8_ft_ls_1v8 "GPIO - 5V tolerant - low speed - 1.8V range"
io8_ft_ms_1v8 "GPIO - 5V tolerant - med speed - 1.8V range"
io8_ft_fs_1v8 "GPIO - 5V tolerant - fast speed - 1.8V range"
io8_ft_hs_1v8 "GPIO - 5V tolerant - high speed - 1.8V range"
io8_ft_ls_1v2 "GPIO - 5V tolerant - low speed - 1.2V range"
io8_ft_ms_1v2 "GPIO - 5V tolerant - med speed - 1.2V range"
io8_ft_fs_1v2 "GPIO - 5V tolerant - fast speed - 1.2V range"
io8_ft_hs_1v2 "GPIO - 5V tolerant - high speed - 1.2V range"
io8_ft_i2c_ls_3v3 "GPIO with I2C open-drain - 5V tolerant - low speed - 3.3V range"
io8_ft_i2c_ms_3v3 "GPIO with I2C open-drain - 5V tolerant - med speed - 3.3V range"
io8_ft_i2c_fs_3v3 "GPIO with I2C open-drain - 5V tolerant - fast speed - 3.3V range"
io8_ft_i2c_hs_3v3 "GPIO with I2C open-drain - 5V tolerant - high speed - 3.3V range"
io8_ft_i2c_ls_1v8 "GPIO with I2C open-drain - 5V tolerant - low speed - 1.8V range"
io8_ft_i2c_ms_1v8 "GPIO with I2C open-drain - 5V tolerant - med speed - 1.8V range"
io8_ft_i2c_fs_1v8 "GPIO with I2C open-drain - 5V tolerant - fast speed - 1.8V range"
io8_ft_i2c_hs_1v8 "GPIO with I2C open-drain - 5V tolerant - high speed - 1.8V range"
io8_ft_i2c_ls_1v2 "GPIO with I2C open-drain - 5V tolerant - low speed - 1.2V range"
io8_ft_i2c_ms_1v2 "GPIO with I2C open-drain - 5V tolerant - med speed - 1.2V range"
io8_ft_i2c_fs_1v2 "GPIO with I2C open-drain - 5V tolerant - fast speed - 1.2V range"
io8_ft_i2c_hs_1v2 "GPIO with I2C open-drain - 5V tolerant - high speed - 1.2V range"
io8_ft_i2c_fmp_3v3 "GPIO with I2C fm+ open-drain - 5V tolerant - 3.3V range"
[Model Selector] io8_ft_i2c_v33
io8_ft_ls_3v3 "GPIO - 5V tolerant - low speed - 3.3V range"
io8_ft_ms_3v3 "GPIO - 5V tolerant - med speed - 3.3V range"
io8_ft_fs_3v3 "GPIO - 5V tolerant - fast speed - 3.3V range"
io8_ft_hs_3v3 "GPIO - 5V tolerant - high speed - 3.3V range"
io8_ft_ls_1v8 "GPIO - 5V tolerant - low speed - 1.8V range"
io8_ft_ms_1v8 "GPIO - 5V tolerant - med speed - 1.8V range"
io8_ft_fs_1v8 "GPIO - 5V tolerant - fast speed - 1.8V range"
io8_ft_hs_1v8 "GPIO - 5V tolerant - high speed - 1.8V range"
io8_ft_ls_1v2 "GPIO - 5V tolerant - low speed - 1.2V range"
io8_ft_ms_1v2 "GPIO - 5V tolerant - med speed - 1.2V range"
io8_ft_fs_1v2 "GPIO - 5V tolerant - fast speed - 1.2V range"
io8_ft_hs_1v2 "GPIO - 5V tolerant - high speed - 1.2V range"
io8_ft_i2c_v33_ls_3v3 "GPIO with I2C open-drain - 5V tolerant - low speed - 3.3V range"
io8_ft_i2c_v33_ms_3v3 "GPIO with I2C open-drain - 5V tolerant - med speed - 3.3V range"
io8_ft_i2c_v33_fs_3v3 "GPIO with I2C open-drain - 5V tolerant - fast speed - 3.3V range"
io8_ft_i2c_v33_hs_3v3 "GPIO with I2C open-drain - 5V tolerant - high speed - 3.3V range"
io8_ft_i2c_v33_ls_1v8 "GPIO with I2C open-drain - 5V tolerant - low speed - 1.8V range"
io8_ft_i2c_v33_ms_1v8 "GPIO with I2C open-drain - 5V tolerant - med speed - 1.8V range"
io8_ft_i2c_v33_fs_1v8 "GPIO with I2C open-drain - 5V tolerant - fast speed - 1.8V range"
io8_ft_i2c_v33_hs_1v8 "GPIO with I2C open-drain - 5V tolerant - high speed - 1.8V range"
io8_ft_i2c_v33_ls_1v2 "GPIO with I2C open-drain - 5V tolerant - low speed - 1.2V range"
io8_ft_i2c_v33_ms_1v2 "GPIO with I2C open-drain - 5V tolerant - med speed - 1.2V range"
io8_ft_i2c_v33_fs_1v2 "GPIO with I2C open-drain - 5V tolerant - fast speed - 1.2V range"
io8_ft_i2c_v33_hs_1v2 "GPIO with I2C open-drain - 5V tolerant - high speed - 1.2V range"
io8_ft_i2c_v33_fmp_3v3 "GPIO with I2C fm+ open-drain - 5V tolerant - 3.3V range"
[Model Selector] io8_ft_v33
io8_ft_v33_ls_3v3 "GPIO - 5V tolerant - low speed - 3.3V range"
io8_ft_v33_ms_3v3 "GPIO - 5V tolerant - med speed - 3.3V range"
io8_ft_v33_fs_3v3 "GPIO - 5V tolerant - fast speed - 3.3V range"
io8_ft_v33_hs_3v3 "GPIO - 5V tolerant - high speed - 3.3V range"
io8_ft_v33_ls_1v8 "GPIO - 5V tolerant - low speed - 1.8V range"
io8_ft_v33_ms_1v8 "GPIO - 5V tolerant - med speed - 1.8V range"
io8_ft_v33_fs_1v8 "GPIO - 5V tolerant - fast speed - 1.8V range"
io8_ft_v33_hs_1v8 "GPIO - 5V tolerant - high speed - 1.8V range"
io8_ft_v33_ls_1v2 "GPIO - 5V tolerant - low speed - 1.2V range"
io8_ft_v33_ms_1v2 "GPIO - 5V tolerant - med speed - 1.2V range"
io8_ft_v33_fs_1v2 "GPIO - 5V tolerant - fast speed - 1.2V range"
io8_ft_v33_hs_1v2 "GPIO - 5V tolerant - high speed - 1.2V range"
[Model Selector] io8usb_ft_i2c_phy
io8_ft_ls_3v3 "GPIO - 5V tolerant - low speed - 3.3V range"
io8_ft_ms_3v3 "GPIO - 5V tolerant - med speed - 3.3V range"
io8_ft_fs_3v3 "GPIO - 5V tolerant - fast speed - 3.3V range"
io8_ft_hs_3v3 "GPIO - 5V tolerant - high speed - 3.3V range"
io8_ft_ls_1v8 "GPIO - 5V tolerant - low speed - 1.8V range"
io8_ft_ms_1v8 "GPIO - 5V tolerant - med speed - 1.8V range"
io8_ft_fs_1v8 "GPIO - 5V tolerant - fast speed - 1.8V range"
io8_ft_hs_1v8 "GPIO - 5V tolerant - high speed - 1.8V range"
io8_ft_ls_1v2 "GPIO - 5V tolerant - low speed - 1.2V range"
io8_ft_ms_1v2 "GPIO - 5V tolerant - med speed - 1.2V range"
io8_ft_fs_1v2 "GPIO - 5V tolerant - fast speed - 1.2V range"
io8_ft_hs_1v2 "GPIO - 5V tolerant - high speed - 1.2V range"
io8_ft_i2c_ls_3v3 "GPIO with I2C open-drain - 5V tolerant - low speed - 3.3V range"
io8_ft_i2c_ms_3v3 "GPIO with I2C open-drain - 5V tolerant - med speed - 3.3V range"
io8_ft_i2c_fs_3v3 "GPIO with I2C open-drain - 5V tolerant - fast speed - 3.3V range"
io8_ft_i2c_hs_3v3 "GPIO with I2C open-drain - 5V tolerant - high speed - 3.3V range"
io8_ft_i2c_ls_1v8 "GPIO with I2C open-drain - 5V tolerant - low speed - 1.8V range"
io8_ft_i2c_ms_1v8 "GPIO with I2C open-drain - 5V tolerant - med speed - 1.8V range"
io8_ft_i2c_fs_1v8 "GPIO with I2C open-drain - 5V tolerant - fast speed - 1.8V range"
io8_ft_i2c_hs_1v8 "GPIO with I2C open-drain - 5V tolerant - high speed - 1.8V range"
io8_ft_i2c_ls_1v2 "GPIO with I2C open-drain - 5V tolerant - low speed - 1.2V range"
io8_ft_i2c_ms_1v2 "GPIO with I2C open-drain - 5V tolerant - med speed - 1.2V range"
io8_ft_i2c_fs_1v2 "GPIO with I2C open-drain - 5V tolerant - fast speed - 1.2V range"
io8_ft_i2c_hs_1v2 "GPIO with I2C open-drain - 5V tolerant - high speed - 1.2V range"
io8_ft_i2c_fmp_3v3 "GPIO with I2C fm+ open-drain - 5V tolerant - 3.3V range"
io8usb_ft_phy_fs_3v3   "USB full speed"
io8usb_ft_phy_ls_3v3   "USB low speed"
[Model Selector] ioreset_ft_v33
io8_ft_v33_ls_3v3 "GPIO - 5V tolerant - low speed - 3.3V range"
io8_ft_v33_ms_3v3 "GPIO - 5V tolerant - med speed - 3.3V range"
io8_ft_v33_fs_3v3 "GPIO - 5V tolerant - fast speed - 3.3V range"
io8_ft_v33_hs_3v3 "GPIO - 5V tolerant - high speed - 3.3V range"
io8_ft_v33_ls_1v8 "GPIO - 5V tolerant - low speed - 1.8V range"
io8_ft_v33_ms_1v8 "GPIO - 5V tolerant - med speed - 1.8V range"
io8_ft_v33_fs_1v8 "GPIO - 5V tolerant - fast speed - 1.8V range"
io8_ft_v33_hs_1v8 "GPIO - 5V tolerant - high speed - 1.8V range"
io8_ft_v33_ls_1v2 "GPIO - 5V tolerant - low speed - 1.2V range"
io8_ft_v33_ms_1v2 "GPIO - 5V tolerant - med speed - 1.2V range"
io8_ft_v33_fs_1v2 "GPIO - 5V tolerant - fast speed - 1.2V range"
io8_ft_v33_hs_1v2 "GPIO - 5V tolerant - high speed - 1.2V range"
ioreset_ft_v33_1v2   "Reset PAD. 5V tolerant. 1.2V range"
ioreset_ft_v33_1v8   "Reset PAD. 5V tolerant. 1.8V range"
ioreset_ft_v33_3v3   "Reset PAD. 5V tolerant. 3.3V range"
[Define Package Model]  493-uqfn-5x5-32-n-240422
[Manufacturer]  Unknown
[OEM]  Unknown
[Description]  None
[Number Of Pins]  32
[Pin Numbers]
| Pin Num   Terminal Name
7 | PA0
8 | PA1
9 | PA2
10 | PA3
11 | PA4
12 | PA5
13 | PA6
14 | PA7
18 | PA8
19 | PA9
21 | PA10
22 | PA11
23 | PA12
24 | PA13
25 | PA14-BOOT0
26 | PA15
15 | PB0
16 | PB1
17 | PB2
27 | PB3
28 | PB4
29 | PB5
30 | PB6
31 | PB7
32 | PB8
1 | PB9
2 | PC14-OSCX_IN
3 | PC15-OSCX_OUT
6 | PF2-NRST
4 | VDD
20 | VDDIO2
5 | VSS
[Model Data]
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[End Model Data]
[End Package Model]
|End [Component]
| Models and submodels in the file (55): io8_ft_fs_1v2 (I/O), io8_ft_fs_1v8 (I/O), io8_ft_fs_3v3 (I/O), io8_ft_hs_1v2 (I/O), io8_ft_hs_1v8 (I/O), io8_ft_hs_3v3 (I/O), io8_ft_i2c_fmp_3v3 (I/O_open_drain), io8_ft_i2c_fs_1v2 (I/O_open_drain), io8_ft_i2c_fs_1v8 (I/O_open_drain), io8_ft_i2c_fs_3v3 (I/O_open_drain), io8_ft_i2c_hs_1v2 (I/O_open_drain), io8_ft_i2c_hs_1v8 (I/O_open_drain), io8_ft_i2c_hs_3v3 (I/O_open_drain), io8_ft_i2c_ls_1v2 (I/O_open_drain), io8_ft_i2c_ls_1v8 (I/O_open_drain), io8_ft_i2c_ls_3v3 (I/O_open_drain), io8_ft_i2c_ms_1v2 (I/O_open_drain), io8_ft_i2c_ms_1v8 (I/O_open_drain), io8_ft_i2c_ms_3v3 (I/O_open_drain), io8_ft_i2c_v33_fmp_3v3 (I/O_open_drain), io8_ft_i2c_v33_fs_1v2 (I/O_open_drain), io8_ft_i2c_v33_fs_1v8 (I/O_open_drain), io8_ft_i2c_v33_fs_3v3 (I/O_open_drain), io8_ft_i2c_v33_hs_1v2 (I/O_open_drain), io8_ft_i2c_v33_hs_1v8 (I/O_open_drain), io8_ft_i2c_v33_hs_3v3 (I/O_open_drain), io8_ft_i2c_v33_ls_1v2 (I/O_open_drain), io8_ft_i2c_v33_ls_1v8 (I/O_open_drain), io8_ft_i2c_v33_ls_3v3 (I/O_open_drain), io8_ft_i2c_v33_ms_1v2 (I/O_open_drain), io8_ft_i2c_v33_ms_1v8 (I/O_open_drain), io8_ft_i2c_v33_ms_3v3 (I/O_open_drain), io8_ft_ls_1v2 (I/O), io8_ft_ls_1v8 (I/O), io8_ft_ls_3v3 (I/O), io8_ft_ms_1v2 (I/O), io8_ft_ms_1v8 (I/O), io8_ft_ms_3v3 (I/O), io8_ft_v33_fs_1v2 (I/O), io8_ft_v33_fs_1v8 (I/O), io8_ft_v33_fs_3v3 (I/O), io8_ft_v33_hs_1v2 (I/O), io8_ft_v33_hs_1v8 (I/O), io8_ft_v33_hs_3v3 (I/O), io8_ft_v33_ls_1v2 (I/O), io8_ft_v33_ls_1v8 (I/O), io8_ft_v33_ls_3v3 (I/O), io8_ft_v33_ms_1v2 (I/O), io8_ft_v33_ms_1v8 (I/O), io8_ft_v33_ms_3v3 (I/O), io8usb_ft_phy_fs_3v3 (I/O), io8usb_ft_phy_ls_3v3 (I/O), ioreset_ft_v33_1v2 (Input), ioreset_ft_v33_1v8 (Input), ioreset_ft_v33_3v3 (Input)
