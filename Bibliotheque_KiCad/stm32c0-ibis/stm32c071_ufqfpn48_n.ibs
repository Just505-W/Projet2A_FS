| IBIS file stm32c071_ufqfpn48_n.ibs
[IBIS ver] 4.2
[File name] stm32c071_ufqfpn48_n.ibs
[File Rev] 0.1
[Date] 27-05-2024
[Source] Data Created at STMicroelectronics
[Notes]  File originated from ELDO simulations.
[Disclaimer]  This information is for modeling purpose only and is
   not guaranteed. The information is subject to change without
   notice.
[Copyright] Copyright 2024 STMicroelectronics Inc.
|   Component stm32c071_ufqfpn48_n
[Component] stm32c071_ufqfpn48_n
[Manufacturer] STMicroelectronics
[Package]
| variable   typ   min   max
R_pkg  0  NA  NA
L_pkg  0  NA  NA
C_pkg  0  NA  NA
[Pin]   signal_name   model_name
1  PC13  io8_ft_v33
2  PC14-OSCX_IN  io8_ft_i2c
3  PC15-OSCX_OUT  io8_ft
4  PF3  io8_ft
5  VREFP  nc
6  VDD  power
7  VSS  gnd
8  PF0-OSC_IN  io8_ft
9  PF1-OSC_OUT  io8_ft
10  PF2-NRST  ioreset_ft_v33
11  PA0  io8_ft_v33
12  PA1  io8_ft
13  PA2  io8_ft_v33
14  PA3  io8_ft
15  PA4  io8_ft_v33
16  PA5  io8_ft
17  PA6  io8_ft_i2c
18  PA7  io8_ft_i2c
19  PB0  io8_ft
20  PB1  io8_ft
21  PB2  io8_ft
22  PB10  io8_ft_i2c
23  PB11  io8_ft_i2c
24  PB12  io8_ft
25  PB13  io8_ft_i2c
26  PB14  io8_ft_i2c
27  PB15  io8_ft
28  PA8  io8_ft
29  PA9  io8_ft_i2c
30  VSS  gnd
31  VDDIO2  power
32  PA10  io8_ft_i2c
33  PA11  io8usb_ft_i2c_phy
34  PA12  io8usb_ft_i2c_phy
35  PA13  io8_ft
36  PA14-BOOT0  io8_ft_v33
37  PA15  io8_ft
38  PD0  io8_ft
39  PD1  io8_ft
40  PD2  io8_ft
41  PD3  io8_ft
42  PB3  io8_ft_i2c
43  PB4  io8_ft_i2c
44  PB5  io8_ft_i2c_v33
45  PB6  io8_ft_i2c_v33
46  PB7  io8_ft_i2c
47  PB8  io8_ft_i2c
48  PB9  io8_ft_i2c
[Package Model]   493-uqfn-7x7-48-n-240422
[Pin Mapping]   pulldown_ref   pullup_ref   | Comment
1  gndio  vddio
2  gndio  vddio
3  gndio  vddio
4  gndio  vddio
5  nc  nc
6  nc  vddio
7  gndio  nc
8  gndio  vddio
9  gndio  vddio
10  gndio  vddio
11  gndio  vddio
12  gndio  vddio
13  gndio  vddio
14  gndio  vddio
15  gndio  vddio
16  gndio  vddio
17  gndio  vddio
18  gndio  vddio
19  gndio  vddio
20  gndio  vddio
21  gndio  vddio
22  gndio  vddio
23  gndio  vddio
24  gndio  vddio
25  gndio  vddio2
26  gndio  vddio2
27  gndio  vddio2
28  gndio  vddio2
29  gndio  vddio2
30  gndio  nc
31  nc  vddio2
32  gndio  vddio2
33  gndio  vddio2
34  gndio  vddio2
35  gndio  vddio2
36  gndio  vddio2
37  gndio  vddio2
38  gndio  vddio2
39  gndio  vddio2
40  gndio  vddio2
41  gndio  vddio2
42  gndio  vddio
43  gndio  vddio
44  gndio  vddio
45  gndio  vddio
46  gndio  vddio
47  gndio  vddio
48  gndio  vddio
|[Diff Pin]  inv_pin  vdiff  tdelay_typ  tdelay_min  tdelay_max
|34  33  NA  NA  NA  NA
[Model Selector] io8_ft
io8_ft_ls_3v3 "GPIO - 5V tolerant - low speed - 3.3V range"
io8_ft_ms_3v3 "GPIO - 5V tolerant - med speed - 3.3V range"
io8_ft_fs_3v3 "GPIO - 5V tolerant - fast speed - 3.3V range"
io8_ft_hs_3v3 "GPIO - 5V tolerant - high speed - 3.3V range"
io8_ft_ls_1v8 "GPIO - 5V tolerant - low speed - 1.8V range"
io8_ft_ms_1v8 "GPIO - 5V tolerant - med speed - 1.8V range"
io8_ft_fs_1v8 "GPIO - 5V tolerant - fast speed - 1.8V range"
io8_ft_hs_1v8 "GPIO - 5V tolerant - high speed - 1.8V range"
io8_ft_ls_1v2 "GPIO - 5V tolerant - low speed - 1.2V range"
io8_ft_ms_1v2 "GPIO - 5V tolerant - med speed - 1.2V range"
io8_ft_fs_1v2 "GPIO - 5V tolerant - fast speed - 1.2V range"
io8_ft_hs_1v2 "GPIO - 5V tolerant - high speed - 1.2V range"
[Model Selector] io8_ft_i2c
io8_ft_ls_3v3 "GPIO - 5V tolerant - low speed - 3.3V range"
io8_ft_ms_3v3 "GPIO - 5V tolerant - med speed - 3.3V range"
io8_ft_fs_3v3 "GPIO - 5V tolerant - fast speed - 3.3V range"
io8_ft_hs_3v3 "GPIO - 5V tolerant - high speed - 3.3V range"
io8_ft_ls_1v8 "GPIO - 5V tolerant - low speed - 1.8V range"
io8_ft_ms_1v8 "GPIO - 5V tolerant - med speed - 1.8V range"
io8_ft_fs_1v8 "GPIO - 5V tolerant - fast speed - 1.8V range"
io8_ft_hs_1v8 "GPIO - 5V tolerant - high speed - 1.8V range"
io8_ft_ls_1v2 "GPIO - 5V tolerant - low speed - 1.2V range"
io8_ft_ms_1v2 "GPIO - 5V tolerant - med speed - 1.2V range"
io8_ft_fs_1v2 "GPIO - 5V tolerant - fast speed - 1.2V range"
io8_ft_hs_1v2 "GPIO - 5V tolerant - high speed - 1.2V range"
io8_ft_i2c_ls_3v3 "GPIO with I2C open-drain - 5V tolerant - low speed - 3.3V range"
io8_ft_i2c_ms_3v3 "GPIO with I2C open-drain - 5V tolerant - med speed - 3.3V range"
io8_ft_i2c_fs_3v3 "GPIO with I2C open-drain - 5V tolerant - fast speed - 3.3V range"
io8_ft_i2c_hs_3v3 "GPIO with I2C open-drain - 5V tolerant - high speed - 3.3V range"
io8_ft_i2c_ls_1v8 "GPIO with I2C open-drain - 5V tolerant - low speed - 1.8V range"
io8_ft_i2c_ms_1v8 "GPIO with I2C open-drain - 5V tolerant - med speed - 1.8V range"
io8_ft_i2c_fs_1v8 "GPIO with I2C open-drain - 5V tolerant - fast speed - 1.8V range"
io8_ft_i2c_hs_1v8 "GPIO with I2C open-drain - 5V tolerant - high speed - 1.8V range"
io8_ft_i2c_ls_1v2 "GPIO with I2C open-drain - 5V tolerant - low speed - 1.2V range"
io8_ft_i2c_ms_1v2 "GPIO with I2C open-drain - 5V tolerant - med speed - 1.2V range"
io8_ft_i2c_fs_1v2 "GPIO with I2C open-drain - 5V tolerant - fast speed - 1.2V range"
io8_ft_i2c_hs_1v2 "GPIO with I2C open-drain - 5V tolerant - high speed - 1.2V range"
io8_ft_i2c_fmp_3v3 "GPIO with I2C fm+ open-drain - 5V tolerant - 3.3V range"
[Model Selector] io8_ft_i2c_v33
io8_ft_ls_3v3 "GPIO - 5V tolerant - low speed - 3.3V range"
io8_ft_ms_3v3 "GPIO - 5V tolerant - med speed - 3.3V range"
io8_ft_fs_3v3 "GPIO - 5V tolerant - fast speed - 3.3V range"
io8_ft_hs_3v3 "GPIO - 5V tolerant - high speed - 3.3V range"
io8_ft_ls_1v8 "GPIO - 5V tolerant - low speed - 1.8V range"
io8_ft_ms_1v8 "GPIO - 5V tolerant - med speed - 1.8V range"
io8_ft_fs_1v8 "GPIO - 5V tolerant - fast speed - 1.8V range"
io8_ft_hs_1v8 "GPIO - 5V tolerant - high speed - 1.8V range"
io8_ft_ls_1v2 "GPIO - 5V tolerant - low speed - 1.2V range"
io8_ft_ms_1v2 "GPIO - 5V tolerant - med speed - 1.2V range"
io8_ft_fs_1v2 "GPIO - 5V tolerant - fast speed - 1.2V range"
io8_ft_hs_1v2 "GPIO - 5V tolerant - high speed - 1.2V range"
io8_ft_i2c_v33_ls_3v3 "GPIO with I2C open-drain - 5V tolerant - low speed - 3.3V range"
io8_ft_i2c_v33_ms_3v3 "GPIO with I2C open-drain - 5V tolerant - med speed - 3.3V range"
io8_ft_i2c_v33_fs_3v3 "GPIO with I2C open-drain - 5V tolerant - fast speed - 3.3V range"
io8_ft_i2c_v33_hs_3v3 "GPIO with I2C open-drain - 5V tolerant - high speed - 3.3V range"
io8_ft_i2c_v33_ls_1v8 "GPIO with I2C open-drain - 5V tolerant - low speed - 1.8V range"
io8_ft_i2c_v33_ms_1v8 "GPIO with I2C open-drain - 5V tolerant - med speed - 1.8V range"
io8_ft_i2c_v33_fs_1v8 "GPIO with I2C open-drain - 5V tolerant - fast speed - 1.8V range"
io8_ft_i2c_v33_hs_1v8 "GPIO with I2C open-drain - 5V tolerant - high speed - 1.8V range"
io8_ft_i2c_v33_ls_1v2 "GPIO with I2C open-drain - 5V tolerant - low speed - 1.2V range"
io8_ft_i2c_v33_ms_1v2 "GPIO with I2C open-drain - 5V tolerant - med speed - 1.2V range"
io8_ft_i2c_v33_fs_1v2 "GPIO with I2C open-drain - 5V tolerant - fast speed - 1.2V range"
io8_ft_i2c_v33_hs_1v2 "GPIO with I2C open-drain - 5V tolerant - high speed - 1.2V range"
io8_ft_i2c_v33_fmp_3v3 "GPIO with I2C fm+ open-drain - 5V tolerant - 3.3V range"
[Model Selector] io8_ft_v33
io8_ft_v33_ls_3v3 "GPIO - 5V tolerant - low speed - 3.3V range"
io8_ft_v33_ms_3v3 "GPIO - 5V tolerant - med speed - 3.3V range"
io8_ft_v33_fs_3v3 "GPIO - 5V tolerant - fast speed - 3.3V range"
io8_ft_v33_hs_3v3 "GPIO - 5V tolerant - high speed - 3.3V range"
io8_ft_v33_ls_1v8 "GPIO - 5V tolerant - low speed - 1.8V range"
io8_ft_v33_ms_1v8 "GPIO - 5V tolerant - med speed - 1.8V range"
io8_ft_v33_fs_1v8 "GPIO - 5V tolerant - fast speed - 1.8V range"
io8_ft_v33_hs_1v8 "GPIO - 5V tolerant - high speed - 1.8V range"
io8_ft_v33_ls_1v2 "GPIO - 5V tolerant - low speed - 1.2V range"
io8_ft_v33_ms_1v2 "GPIO - 5V tolerant - med speed - 1.2V range"
io8_ft_v33_fs_1v2 "GPIO - 5V tolerant - fast speed - 1.2V range"
io8_ft_v33_hs_1v2 "GPIO - 5V tolerant - high speed - 1.2V range"
[Model Selector] io8usb_ft_i2c_phy
io8_ft_ls_3v3 "GPIO - 5V tolerant - low speed - 3.3V range"
io8_ft_ms_3v3 "GPIO - 5V tolerant - med speed - 3.3V range"
io8_ft_fs_3v3 "GPIO - 5V tolerant - fast speed - 3.3V range"
io8_ft_hs_3v3 "GPIO - 5V tolerant - high speed - 3.3V range"
io8_ft_ls_1v8 "GPIO - 5V tolerant - low speed - 1.8V range"
io8_ft_ms_1v8 "GPIO - 5V tolerant - med speed - 1.8V range"
io8_ft_fs_1v8 "GPIO - 5V tolerant - fast speed - 1.8V range"
io8_ft_hs_1v8 "GPIO - 5V tolerant - high speed - 1.8V range"
io8_ft_ls_1v2 "GPIO - 5V tolerant - low speed - 1.2V range"
io8_ft_ms_1v2 "GPIO - 5V tolerant - med speed - 1.2V range"
io8_ft_fs_1v2 "GPIO - 5V tolerant - fast speed - 1.2V range"
io8_ft_hs_1v2 "GPIO - 5V tolerant - high speed - 1.2V range"
io8_ft_i2c_ls_3v3 "GPIO with I2C open-drain - 5V tolerant - low speed - 3.3V range"
io8_ft_i2c_ms_3v3 "GPIO with I2C open-drain - 5V tolerant - med speed - 3.3V range"
io8_ft_i2c_fs_3v3 "GPIO with I2C open-drain - 5V tolerant - fast speed - 3.3V range"
io8_ft_i2c_hs_3v3 "GPIO with I2C open-drain - 5V tolerant - high speed - 3.3V range"
io8_ft_i2c_ls_1v8 "GPIO with I2C open-drain - 5V tolerant - low speed - 1.8V range"
io8_ft_i2c_ms_1v8 "GPIO with I2C open-drain - 5V tolerant - med speed - 1.8V range"
io8_ft_i2c_fs_1v8 "GPIO with I2C open-drain - 5V tolerant - fast speed - 1.8V range"
io8_ft_i2c_hs_1v8 "GPIO with I2C open-drain - 5V tolerant - high speed - 1.8V range"
io8_ft_i2c_ls_1v2 "GPIO with I2C open-drain - 5V tolerant - low speed - 1.2V range"
io8_ft_i2c_ms_1v2 "GPIO with I2C open-drain - 5V tolerant - med speed - 1.2V range"
io8_ft_i2c_fs_1v2 "GPIO with I2C open-drain - 5V tolerant - fast speed - 1.2V range"
io8_ft_i2c_hs_1v2 "GPIO with I2C open-drain - 5V tolerant - high speed - 1.2V range"
io8_ft_i2c_fmp_3v3 "GPIO with I2C fm+ open-drain - 5V tolerant - 3.3V range"
io8usb_ft_phy_fs_3v3   "USB full speed"
io8usb_ft_phy_ls_3v3   "USB low speed"
[Model Selector] ioreset_ft_v33
io8_ft_v33_ls_3v3 "GPIO - 5V tolerant - low speed - 3.3V range"
io8_ft_v33_ms_3v3 "GPIO - 5V tolerant - med speed - 3.3V range"
io8_ft_v33_fs_3v3 "GPIO - 5V tolerant - fast speed - 3.3V range"
io8_ft_v33_hs_3v3 "GPIO - 5V tolerant - high speed - 3.3V range"
io8_ft_v33_ls_1v8 "GPIO - 5V tolerant - low speed - 1.8V range"
io8_ft_v33_ms_1v8 "GPIO - 5V tolerant - med speed - 1.8V range"
io8_ft_v33_fs_1v8 "GPIO - 5V tolerant - fast speed - 1.8V range"
io8_ft_v33_hs_1v8 "GPIO - 5V tolerant - high speed - 1.8V range"
io8_ft_v33_ls_1v2 "GPIO - 5V tolerant - low speed - 1.2V range"
io8_ft_v33_ms_1v2 "GPIO - 5V tolerant - med speed - 1.2V range"
io8_ft_v33_fs_1v2 "GPIO - 5V tolerant - fast speed - 1.2V range"
io8_ft_v33_hs_1v2 "GPIO - 5V tolerant - high speed - 1.2V range"
ioreset_ft_v33_1v2   "Reset PAD. 5V tolerant. 1.2V range"
ioreset_ft_v33_1v8   "Reset PAD. 5V tolerant. 1.8V range"
ioreset_ft_v33_3v3   "Reset PAD. 5V tolerant. 3.3V range"
[Define Package Model]  493-uqfn-7x7-48-n-240422
[Manufacturer]  Unknown
[OEM]  Unknown
[Description]  None
[Number Of Pins]  48
[Pin Numbers]
| Pin Num   Terminal Name
11 | PA0
12 | PA1
13 | PA2
14 | PA3
15 | PA4
16 | PA5
17 | PA6
18 | PA7
28 | PA8
29 | PA9
32 | PA10
33 | PA11
34 | PA12
35 | PA13
36 | PA14-BOOT0
37 | PA15
19 | PB0
20 | PB1
21 | PB2
42 | PB3
43 | PB4
44 | PB5
45 | PB6
46 | PB7
47 | PB8
48 | PB9
22 | PB10
23 | PB11
24 | PB12
25 | PB13
26 | PB14
27 | PB15
1 | PC13
2 | PC14-OSCX_IN
3 | PC15-OSCX_OUT
38 | PD0
39 | PD1
40 | PD2
41 | PD3
8 | PF0-OSC_IN
9 | PF1-OSC_OUT
10 | PF2-NRST
4 | PF3
6 | VDD
31 | VDDIO2
5 | VREFP
7 | VSS
30 | VSS
[Model Data]
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[End Model Data]
[End Package Model]
|End [Component]
| Models and submodels in the file (55): io8_ft_fs_1v2 (I/O), io8_ft_fs_1v8 (I/O), io8_ft_fs_3v3 (I/O), io8_ft_hs_1v2 (I/O), io8_ft_hs_1v8 (I/O), io8_ft_hs_3v3 (I/O), io8_ft_i2c_fmp_3v3 (I/O_open_drain), io8_ft_i2c_fs_1v2 (I/O_open_drain), io8_ft_i2c_fs_1v8 (I/O_open_drain), io8_ft_i2c_fs_3v3 (I/O_open_drain), io8_ft_i2c_hs_1v2 (I/O_open_drain), io8_ft_i2c_hs_1v8 (I/O_open_drain), io8_ft_i2c_hs_3v3 (I/O_open_drain), io8_ft_i2c_ls_1v2 (I/O_open_drain), io8_ft_i2c_ls_1v8 (I/O_open_drain), io8_ft_i2c_ls_3v3 (I/O_open_drain), io8_ft_i2c_ms_1v2 (I/O_open_drain), io8_ft_i2c_ms_1v8 (I/O_open_drain), io8_ft_i2c_ms_3v3 (I/O_open_drain), io8_ft_i2c_v33_fmp_3v3 (I/O_open_drain), io8_ft_i2c_v33_fs_1v2 (I/O_open_drain), io8_ft_i2c_v33_fs_1v8 (I/O_open_drain), io8_ft_i2c_v33_fs_3v3 (I/O_open_drain), io8_ft_i2c_v33_hs_1v2 (I/O_open_drain), io8_ft_i2c_v33_hs_1v8 (I/O_open_drain), io8_ft_i2c_v33_hs_3v3 (I/O_open_drain), io8_ft_i2c_v33_ls_1v2 (I/O_open_drain), io8_ft_i2c_v33_ls_1v8 (I/O_open_drain), io8_ft_i2c_v33_ls_3v3 (I/O_open_drain), io8_ft_i2c_v33_ms_1v2 (I/O_open_drain), io8_ft_i2c_v33_ms_1v8 (I/O_open_drain), io8_ft_i2c_v33_ms_3v3 (I/O_open_drain), io8_ft_ls_1v2 (I/O), io8_ft_ls_1v8 (I/O), io8_ft_ls_3v3 (I/O), io8_ft_ms_1v2 (I/O), io8_ft_ms_1v8 (I/O), io8_ft_ms_3v3 (I/O), io8_ft_v33_fs_1v2 (I/O), io8_ft_v33_fs_1v8 (I/O), io8_ft_v33_fs_3v3 (I/O), io8_ft_v33_hs_1v2 (I/O), io8_ft_v33_hs_1v8 (I/O), io8_ft_v33_hs_3v3 (I/O), io8_ft_v33_ls_1v2 (I/O), io8_ft_v33_ls_1v8 (I/O), io8_ft_v33_ls_3v3 (I/O), io8_ft_v33_ms_1v2 (I/O), io8_ft_v33_ms_1v8 (I/O), io8_ft_v33_ms_3v3 (I/O), io8usb_ft_phy_fs_3v3 (I/O), io8usb_ft_phy_ls_3v3 (I/O), ioreset_ft_v33_1v2 (Input), ioreset_ft_v33_1v8 (Input), ioreset_ft_v33_3v3 (Input)
